* Numeric LVS reference for neuron_core, generated by scripts/lvs_ref.py from:
*   spice/bias/bias_ref.spice
*   spice/neuron/ota5p.spice
*   spice/neuron/vi_conv.spice
*   spice/neuron/neuron_core.spice
* Do not edit: regenerate instead.

.subckt bias_ref VDD VSS VP VN
XM1 VN VN VSS VSS sky130_fd_pr__nfet_01v8 W=20 L=2 nf=1 m=1
XM2 VP VN NS  VSS sky130_fd_pr__nfet_01v8 W=20 L=2 nf=1 m=4
XR1 NS VSS VSS sky130_fd_pr__res_xhigh_po_1p41 L=17
XM3 VN VP VDD VDD sky130_fd_pr__pfet_01v8 W=16 L=2 nf=1 m=1
XM4 VP VP VDD VDD sky130_fd_pr__pfet_01v8 W=16 L=2 nf=1 m=1
XMS1A ST1 VSS VDD VDD sky130_fd_pr__pfet_01v8 W=0.42 L=40 nf=1 m=1
XMS1B ST  VSS ST1 VDD sky130_fd_pr__pfet_01v8 W=0.42 L=40 nf=1 m=1
XMS2  ST  VN  VSS VSS sky130_fd_pr__nfet_01v8 W=16 L=0.5 nf=1 m=1
XMS3  VDD ST  VN  VSS sky130_fd_pr__nfet_01v8 W=1 L=1 nf=1 m=1
.ends bias_ref

.subckt ota5p INP INN OUT VP VDD VSS
XMT T   VP  VDD VDD sky130_fd_pr__pfet_01v8 W=16 L=2 nf=1 m=1
XM1 D1  INP T   T   sky130_fd_pr__pfet_01v8 W=10   L=1   nf=1 m=1
XM2 OUT INN T   T   sky130_fd_pr__pfet_01v8 W=10   L=1   nf=1 m=1
XM3 D1  D1  VSS VSS sky130_fd_pr__nfet_01v8 W=2   L=2   nf=1 m=1
XM4 OUT D1  VSS VSS sky130_fd_pr__nfet_01v8 W=2   L=2   nf=1 m=1
.ends ota5p

.subckt vi_conv IN VREF G VP VDD VSS
XR  IN  X   VSS sky130_fd_pr__res_xhigh_po_0p69 L=103.53
XA X VREF G VP VDD VSS ota5p
XMF X   G   VSS VSS sky130_fd_pr__nfet_01v8 W=16 L=4 nf=1 m=1
XI0 X   VP  VDD VDD sky130_fd_pr__pfet_01v8 W=16 L=4 nf=1 m=1
XRZ G   GC  VSS sky130_fd_pr__res_xhigh_po_0p69 L=25
XCC GC  X   sky130_fd_pr__cap_mim_m3_1 W=20 L=20
.ends vi_conv

.subckt neuron_core X Y VDD VSS
XBIAS VDD VSS VP VN bias_ref
XRA VDD  VK   VSS sky130_fd_pr__res_xhigh_po_0p69 L=133.11
XRB VK   VREF VSS sky130_fd_pr__res_xhigh_po_0p69 L=59.16
XRC VREF VSS  VSS sky130_fd_pr__res_xhigh_po_0p69 L=44.37
XVS X VREF GS VP VDD VSS vi_conv
XVK VK VREF GK VP VDD VSS vi_conv
XWS S    GS VSS VSS sky130_fd_pr__nfet_01v8 W=16 L=4 nf=1 m=2
XWK DK   GK VSS VSS sky130_fd_pr__nfet_01v8 W=16 L=4 nf=1 m=2
XPK1 DK  DK VDD VDD sky130_fd_pr__pfet_01v8 W=32 L=4 nf=1 m=1
XPK2 S   DK VDD VDD sky130_fd_pr__pfet_01v8 W=32 L=4 nf=1 m=1
XPR1 S   S  VDD VDD sky130_fd_pr__pfet_01v8 W=32 L=8 nf=1 m=1
XPR2 Y   S  VDD VDD sky130_fd_pr__pfet_01v8 W=32 L=8 nf=1 m=1
XRO Y    VSS VSS sky130_fd_pr__res_xhigh_po_0p69 L=103.53
.ends neuron_core
