* Numeric LVS reference for ota5p, generated by scripts/lvs_ref.py from:
*   spice/neuron/ota5p.spice
* Do not edit: regenerate instead.

.subckt ota5p INP INN OUT VP VDD VSS
XMT T   VP  VDD VDD sky130_fd_pr__pfet_01v8 W=16 L=2 nf=1 m=1
XM1 D1  INP T   T   sky130_fd_pr__pfet_01v8 W=10   L=1   nf=1 m=1
XM2 OUT INN T   T   sky130_fd_pr__pfet_01v8 W=10   L=1   nf=1 m=1
XM3 D1  D1  VSS VSS sky130_fd_pr__nfet_01v8 W=2   L=2   nf=1 m=1
XM4 OUT D1  VSS VSS sky130_fd_pr__nfet_01v8 W=2   L=2   nf=1 m=1
.ends ota5p
