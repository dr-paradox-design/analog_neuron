* Numeric LVS reference for bias_ref, generated by scripts/lvs_ref.py from:
*   spice/bias/bias_ref.spice
* Do not edit: regenerate instead.

.subckt bias_ref VDD VSS VP VN
XM1 VN VN VSS VSS sky130_fd_pr__nfet_01v8 W=20 L=2 nf=1 m=1
XM2 VP VN NS  VSS sky130_fd_pr__nfet_01v8 W=20 L=2 nf=1 m=4
XR1 NS VSS VSS sky130_fd_pr__res_xhigh_po_1p41 L=17
XM3 VN VP VDD VDD sky130_fd_pr__pfet_01v8 W=16 L=2 nf=1 m=1
XM4 VP VP VDD VDD sky130_fd_pr__pfet_01v8 W=16 L=2 nf=1 m=1
XMS1A ST1 VSS VDD VDD sky130_fd_pr__pfet_01v8 W=0.42 L=40 nf=1 m=1
XMS1B ST  VSS ST1 VDD sky130_fd_pr__pfet_01v8 W=0.42 L=40 nf=1 m=1
XMS2  ST  VN  VSS VSS sky130_fd_pr__nfet_01v8 W=16 L=0.5 nf=1 m=1
XMS3  VDD ST  VN  VSS sky130_fd_pr__nfet_01v8 W=1 L=1 nf=1 m=1
.ends bias_ref
