* Single-input current-mode ReLU neuron core:  y = 2 * (R_out/R_in) * max(0, x - V_k)
*
*  VDD ─ Ra(9u) ─┬─ VK ─ Rb(4u) ─┬─ VREF ─ Rc(3u) ─ VSS     u = unit xhigh_po 0.69 x 14.79 um (~41 k)
*                │                │
*  X  ── R_in(7u) ── XVS (V->I) ── GS ─► XWS (x2) sinks 2(I_x + I0) from S
*  VK ── R_k (7u) ── XVK (V->I) ── GK ─► XWK (x2) sinks 2(I_k + I0) from DK
*                                         XPK1 (diode at DK) / XPK2 sources 2(I_k + I0) into S
*  S: XPR1 (PMOS diode) supplies only the excess 2(I_x - I_k) > 0   → ReLU
*  XPR2 copies it into R_out(7u) → Y
*
*  I_x = (x - VREF)/R_in, I_k = (VK - VREF)/R_in; VREF and I0 cancel.
*  Divider: R_k draws (VK - VREF)/R_k out of VK but returns it to VSS through MF_k, not into
*  VREF, so  VK = VREF (1 + Rb/Rc)  and  (VDD - VK)/Ra = (VK - VREF)(1/Rb + 1/R_k).
*  With Ra:Rb:Rc:R_k = 9:4:3:7 → VREF = 0.1419 VDD (0.255 V), VK = 0.331 VDD (0.596 V).
* Sizing parameters: mf_w/mf_l set MF in both converters AND the x2 weight copies (they must
* stay identical for an exact ratio of 2); i0_*, ota_* are passed to vi_conv.
* Defaults = MC study variant C (2026-10-15): mirror/flip/I0 at 4x the original area (same W/L),
* slope sigma 2.81 % -> 1.36 %, knee sigma 49.7 -> 23.7 mV; OTA upsizing gained only 1 mV.
* The 4x mirror gate area loads the compensation node, so Cc is 0.80 pF (20x20 MIM) and Rz
* 25 um (~72k): worst phase margin 71.7 deg (was 48.8 deg with the old 0.45 pF / 49k).
* rscale models a global xhigh_po sheet-resistance shift (PDK corners do not vary it): it
* scales every resistor in the block, including the bias reference and the Rz nulling resistors.
.subckt neuron_core X Y VDD VSS rscale=1 pk_w=32 pk_l=4 pr_w=32 pr_l=8 mf_w=16 mf_l=4
+ i0_w=16 i0_l=4 ota_in_w=10 ota_in_l=1 ota_ld_w=2 ota_ld_l=2
.param ru={14.79*rscale}
XBIAS VDD VSS VP VN bias_ref r_l={17*rscale}
XRA VDD  VK   VSS sky130_fd_pr__res_xhigh_po_0p69 L={9*ru}
XRB VK   VREF VSS sky130_fd_pr__res_xhigh_po_0p69 L={4*ru}
XRC VREF VSS  VSS sky130_fd_pr__res_xhigh_po_0p69 L={3*ru}
XVS X    VREF GS VP VDD VSS vi_conv r_l={7*ru}
+ rz_l={25*rscale} mf_w={mf_w} mf_l={mf_l} i0_w={i0_w} i0_l={i0_l} ota_in_w={ota_in_w} ota_in_l={ota_in_l} ota_ld_w={ota_ld_w} ota_ld_l={ota_ld_l}
XVK VK   VREF GK VP VDD VSS vi_conv r_l={7*ru}
+ rz_l={25*rscale} mf_w={mf_w} mf_l={mf_l} i0_w={i0_w} i0_l={i0_l} ota_in_w={ota_in_w} ota_in_l={ota_in_l} ota_ld_w={ota_ld_w} ota_ld_l={ota_ld_l}
* weight mirrors (w = 2: m=2 copies of MF)
XWS S    GS VSS VSS sky130_fd_pr__nfet_01v8 W={mf_w} L={mf_l} nf=1 m=2
XWK DK   GK VSS VSS sky130_fd_pr__nfet_01v8 W={mf_w} L={mf_l} nf=1 m=2
* knee current flipped to a source into S
XPK1 DK  DK VDD VDD sky130_fd_pr__pfet_01v8 W={pk_w} L={pk_l} nf=1 m=1
XPK2 S   DK VDD VDD sky130_fd_pr__pfet_01v8 W={pk_w} L={pk_l} nf=1 m=1
* ReLU diode and output copy
XPR1 S   S  VDD VDD sky130_fd_pr__pfet_01v8 W={pr_w} L={pr_l} nf=1 m=1
XPR2 Y   S  VDD VDD sky130_fd_pr__pfet_01v8 W={pr_w} L={pr_l} nf=1 m=1
XRO Y    VSS VSS sky130_fd_pr__res_xhigh_po_0p69 L={7*ru}
.ends neuron_core
