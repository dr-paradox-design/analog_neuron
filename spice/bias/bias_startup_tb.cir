* Bias reference start-up transient — rendered by scripts/sim.py
* Three copies, each on its own supply profile:
*   F: 0 -> VDD in 1 us     M: 0 -> VDD in 100 us
*   D: up in 10 us, brown-out dip to 0.8 V at 300 us for 50 us, back up
* Very slow ramps are covered by bias_dcramp_tb.cir (quasi-static DC sweep of VDD):
* a 5 ms transient ramp stalls ngspice on the femtoamp start-up nodes while all
* devices are still off (VDD ≈ 0.4–0.6 V), without any circuit activity.
.lib @LIB@ @CORNER@
.include @DIR@/bias_ref.spice
.temp @TEMP@
.param rl=17

VDF vdf 0 PWL(0 0 1u @VDD@)
VDM vdm 0 PWL(0 0 100u @VDD@)
VDD vdd 0 PWL(0 0 10u @VDD@ 300u @VDD@ 301u 0.8 351u 0.8 352u @VDD@)

XBF vdf 0 vpf vnf bias_ref r_l={rl}
XBM vdm 0 vpm vnm bias_ref r_l={rl}
XBD vdd 0 vpd vnd bias_ref r_l={rl}

* delivered current: NMOS copy of M1 sinking from a fixed 0.9 V node
XOF of vnf 0 0 sky130_fd_pr__nfet_01v8 W=20 L=2 nf=1 m=1
VOF of 0 0.9
XOM om vnm 0 0 sky130_fd_pr__nfet_01v8 W=20 L=2 nf=1 m=1
VOM om 0 0.9
XOD od vnd 0 0 sky130_fd_pr__nfet_01v8 W=20 L=2 nf=1 m=1
VOD od 0 0.9

.control
tran 100n 600u 0 1u
let i_f = -i(VOF)
let i_m = -i(VOM)
let i_d = -i(VOD)
meas tran i_fast   avg i_f from=580u to=600u
meas tran i_med    avg i_m from=580u to=600u
meas tran i_dip    avg i_d from=580u to=600u
meas tran i_predip avg i_d from=280u to=300u
meas tran t_fast90 when i_f=0.9*i_fast rise=1
meas tran t_med90  when i_m=0.9*i_med rise=1
meas tran t_dip90  when i_d=0.9*i_dip rise=last
meas tran st_end   find v(xbm.st) at=600u
echo "RESULT i_fast   $&i_fast"
echo "RESULT i_med    $&i_med"
echo "RESULT i_dip    $&i_dip"
echo "RESULT i_predip $&i_predip"
echo "RESULT t_fast90 $&t_fast90"
echo "RESULT t_med90  $&t_med90"
echo "RESULT t_dip90  $&t_dip90"
echo "RESULT st_end   $&st_end"
quit
.endc
.end
