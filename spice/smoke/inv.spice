* CMOS inverter — Phase 0 smoke-test cell
* Also the LVS reference netlist for mag/smoke/inv.mag
.subckt inv A Y VDD VSS
XMP Y A VDD VDD sky130_fd_pr__pfet_01v8 W=2 L=0.15 nf=1
XMN Y A VSS VSS sky130_fd_pr__nfet_01v8 W=1 L=0.15 nf=1
.ends inv
